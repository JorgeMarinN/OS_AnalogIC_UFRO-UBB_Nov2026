* Extracted by KLayout with SG13G2 LVS runset on : 11/11/2026 06:03

.SUBCKT large_delay_vto1p1
M$1 \$5 \$6 \$1 \$1 sg13_lv_nmos L=0.13u W=0.42u AS=0.1428p AD=0.0798p PS=1.52u
+ PD=0.8u rfmode=0
M$2 \$1 \$5 \$7 \$1 sg13_lv_nmos L=0.5u W=0.42u AS=0.0798p AD=0.1428p PS=0.8u
+ PD=1.52u rfmode=0
M$3 \$9 \$2 \$1 \$1 sg13_lv_nmos L=0.13u W=0.42u AS=0.1428p AD=0.0798p PS=1.52u
+ PD=0.8u rfmode=0
M$4 \$1 \$9 \$10 \$1 sg13_lv_nmos L=0.5u W=0.42u AS=0.0798p AD=0.1428p PS=0.8u
+ PD=1.52u rfmode=0
M$5 \$12 \$3 \$1 \$1 sg13_lv_nmos L=0.13u W=0.42u AS=0.1428p AD=0.0798p
+ PS=1.52u PD=0.8u rfmode=0
M$6 \$1 \$12 \$13 \$1 sg13_lv_nmos L=0.5u W=0.42u AS=0.0798p AD=0.1428p PS=0.8u
+ PD=1.52u rfmode=0
M$7 \$1 \$7 \$8 \$1 sg13_lv_nmos L=0.5u W=0.42u AS=0.1426p AD=0.1428p PS=1.16u
+ PD=1.52u rfmode=0
M$8 \$1 \$8 \$2 \$1 sg13_lv_nmos L=0.13u W=0.74u AS=0.1426p AD=0.2516p PS=1.16u
+ PD=2.16u rfmode=0
M$9 \$1 \$10 \$11 \$1 sg13_lv_nmos L=0.5u W=0.42u AS=0.1426p AD=0.1428p
+ PS=1.16u PD=1.52u rfmode=0
M$10 \$1 \$11 \$3 \$1 sg13_lv_nmos L=0.13u W=0.74u AS=0.1426p AD=0.2516p
+ PS=1.16u PD=2.16u rfmode=0
M$11 \$1 \$13 \$14 \$1 sg13_lv_nmos L=0.5u W=0.42u AS=0.1426p AD=0.1428p
+ PS=1.16u PD=1.52u rfmode=0
M$12 \$1 \$14 \$4 \$1 sg13_lv_nmos L=0.13u W=0.74u AS=0.1426p AD=0.2516p
+ PS=1.16u PD=2.16u rfmode=0
M$13 \$15 \$6 \$5 \$15 sg13_lv_pmos L=0.13u W=0.42u AS=0.1523p AD=0.1428p
+ PS=1.38u PD=1.52u rfmode=0
M$14 \$15 \$5 \$7 \$15 sg13_lv_pmos L=0.5u W=1u AS=0.1523p AD=0.34p PS=1.38u
+ PD=2.68u rfmode=0
M$15 \$15 \$2 \$9 \$15 sg13_lv_pmos L=0.13u W=0.42u AS=0.1523p AD=0.1428p
+ PS=1.38u PD=1.52u rfmode=0
M$16 \$15 \$9 \$10 \$15 sg13_lv_pmos L=0.5u W=1u AS=0.1523p AD=0.34p PS=1.38u
+ PD=2.68u rfmode=0
M$17 \$15 \$3 \$12 \$15 sg13_lv_pmos L=0.13u W=0.42u AS=0.1523p AD=0.1428p
+ PS=1.38u PD=1.52u rfmode=0
M$18 \$15 \$12 \$13 \$15 sg13_lv_pmos L=0.5u W=1u AS=0.1523p AD=0.34p PS=1.38u
+ PD=2.68u rfmode=0
M$19 \$8 \$7 \$15 \$15 sg13_lv_pmos L=0.5u W=1u AS=0.34p AD=0.2254p PS=2.68u
+ PD=1.53u rfmode=0
M$20 \$15 \$8 \$2 \$15 sg13_lv_pmos L=0.13u W=1.12u AS=0.2254p AD=0.4256p
+ PS=1.53u PD=3u rfmode=0
M$21 \$11 \$10 \$15 \$15 sg13_lv_pmos L=0.5u W=1u AS=0.34p AD=0.2254p PS=2.68u
+ PD=1.53u rfmode=0
M$22 \$15 \$11 \$3 \$15 sg13_lv_pmos L=0.13u W=1.12u AS=0.2254p AD=0.4256p
+ PS=1.53u PD=3u rfmode=0
M$23 \$14 \$13 \$15 \$15 sg13_lv_pmos L=0.5u W=1u AS=0.34p AD=0.2254p PS=2.68u
+ PD=1.53u rfmode=0
M$24 \$15 \$14 \$4 \$15 sg13_lv_pmos L=0.13u W=1.12u AS=0.2254p AD=0.4256p
+ PS=1.53u PD=3u rfmode=0
.ENDS large_delay_vto1p1
