* Extracted by KLayout with SG13G2 LVS runset on : 11/11/2026 06:02

.SUBCKT large_delay_vto1p1
X$1 \$I2 \$1 \$I6 \$3 sg13g2_dlygate4sd3_1
X$2 \$I2 \$1 \$3 \$2 sg13g2_dlygate4sd3_1
X$3 \$I2 \$1 \$2 \$I7 sg13g2_dlygate4sd3_1
.ENDS large_delay_vto1p1

.SUBCKT sg13g2_dlygate4sd3_1 \$1 \$2 \$3 \$7
M$1 \$2 \$5 \$4 \$2 sg13_lv_nmos L=0.5u W=0.42u AS=0.1426p AD=0.1428p PS=1.16u
+ PD=1.52u rfmode=0
M$2 \$2 \$4 \$3 \$2 sg13_lv_nmos L=0.13u W=0.74u AS=0.1426p AD=0.2516p PS=1.16u
+ PD=2.16u rfmode=0
M$3 \$6 \$7 \$2 \$2 sg13_lv_nmos L=0.13u W=0.42u AS=0.1428p AD=0.0798p PS=1.52u
+ PD=0.8u rfmode=0
M$4 \$2 \$6 \$5 \$2 sg13_lv_nmos L=0.5u W=0.42u AS=0.0798p AD=0.1428p PS=0.8u
+ PD=1.52u rfmode=0
M$5 \$4 \$5 \$1 \$1 sg13_lv_pmos L=0.5u W=1u AS=0.34p AD=0.2254p PS=2.68u
+ PD=1.53u rfmode=0
M$6 \$1 \$4 \$3 \$1 sg13_lv_pmos L=0.13u W=1.12u AS=0.2254p AD=0.4256p PS=1.53u
+ PD=3u rfmode=0
M$7 \$1 \$7 \$6 \$1 sg13_lv_pmos L=0.13u W=0.42u AS=0.1523p AD=0.1428p PS=1.38u
+ PD=1.52u rfmode=0
M$8 \$1 \$6 \$5 \$1 sg13_lv_pmos L=0.5u W=1u AS=0.1523p AD=0.34p PS=1.38u
+ PD=2.68u rfmode=0
.ENDS sg13g2_dlygate4sd3_1
